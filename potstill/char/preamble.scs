simulator lang=spectre

// Copied verbatim from ADE-generated input.scs
include "/usr/pack/umc-65-kgf/umc/ll/tech/Designkits/Cadence_6.1/B11_PB/umc65ll/../Models/Spectre/l65ll_v181.lib.scs" section=tt_ll_rvt12
include "/usr/pack/umc-65-kgf/umc/ll/tech/Designkits/Cadence_6.1/B11_PB/umc65ll/../Models/Spectre/l65ll_v181.lib.scs" section=tt_ll_hvt12
include "/usr/pack/umc-65-kgf/umc/ll/tech/Designkits/Cadence_6.1/B11_PB/umc65ll/../Models/Spectre/l65ll_v181.lib.scs" section=tt_ll_lvt12
include "/usr/pack/umc-65-kgf/umc/ll/tech/Designkits/Cadence_6.1/B11_PB/umc65ll/../Models/Spectre/l65ll_v181.lib.scs" section=tt_ll_io18
include "/usr/pack/umc-65-kgf/umc/ll/tech/Designkits/Cadence_6.1/B11_PB/umc65ll/../Models/Spectre/l65ll_v181.lib.scs" section=tt_ll_io25od33
include "/usr/pack/umc-65-kgf/umc/ll/tech/Designkits/Cadence_6.1/B11_PB/umc65ll/../Models/Spectre/l65ll_v181.lib.scs" section=tt_ll_io33
include "/usr/pack/umc-65-kgf/umc/ll/tech/Designkits/Cadence_6.1/B11_PB/umc65ll/../Models/Spectre/l65ll_v181.lib.scs" section=tt_ll_nvt12
include "/usr/pack/umc-65-kgf/umc/ll/tech/Designkits/Cadence_6.1/B11_PB/umc65ll/../Models/Spectre/l65ll_v181.lib.scs" section=tt_ll_nvt12_bpw
include "/usr/pack/umc-65-kgf/umc/ll/tech/Designkits/Cadence_6.1/B11_PB/umc65ll/../Models/Spectre/l65ll_v181.lib.scs" section=tt_ll_nvt18
include "/usr/pack/umc-65-kgf/umc/ll/tech/Designkits/Cadence_6.1/B11_PB/umc65ll/../Models/Spectre/l65ll_v181.lib.scs" section=tt_ll_nvt18_bpw
include "/usr/pack/umc-65-kgf/umc/ll/tech/Designkits/Cadence_6.1/B11_PB/umc65ll/../Models/Spectre/l65ll_v181.lib.scs" section=tt_ll_nvt25od33
include "/usr/pack/umc-65-kgf/umc/ll/tech/Designkits/Cadence_6.1/B11_PB/umc65ll/../Models/Spectre/l65ll_v181.lib.scs" section=tt_ll_nvt25od33_bpw
include "/usr/pack/umc-65-kgf/umc/ll/tech/Designkits/Cadence_6.1/B11_PB/umc65ll/../Models/Spectre/l65ll_v181.lib.scs" section=tt_ll_nvt33
include "/usr/pack/umc-65-kgf/umc/ll/tech/Designkits/Cadence_6.1/B11_PB/umc65ll/../Models/Spectre/l65ll_v181.lib.scs" section=tt_ll_nvt33_bpw
include "/usr/pack/umc-65-kgf/umc/ll/tech/Designkits/Cadence_6.1/B11_PB/umc65ll/../Models/Spectre/l65ll_v181.lib.scs" section=tt_ll_bjt
include "/usr/pack/umc-65-kgf/umc/ll/tech/Designkits/Cadence_6.1/B11_PB/umc65ll/../Models/Spectre/l65ll_v181.lib.scs" section=tt_ll_diode
include "/usr/pack/umc-65-kgf/umc/ll/tech/Designkits/Cadence_6.1/B11_PB/umc65ll/../Models/Spectre/l65ll_v181.lib.scs" section=tt_ll_momcaps
include "/usr/pack/umc-65-kgf/umc/ll/tech/Designkits/Cadence_6.1/B11_PB/umc65ll/../Models/Spectre/l65ll_v181.lib.scs" section=tt_ll_ncap12
include "/usr/pack/umc-65-kgf/umc/ll/tech/Designkits/Cadence_6.1/B11_PB/umc65ll/../Models/Spectre/l65ll_v181.lib.scs" section=tt_ll_ncap18
include "/usr/pack/umc-65-kgf/umc/ll/tech/Designkits/Cadence_6.1/B11_PB/umc65ll/../Models/Spectre/l65ll_v181.lib.scs" section=tt_ll_ncap25
include "/usr/pack/umc-65-kgf/umc/ll/tech/Designkits/Cadence_6.1/B11_PB/umc65ll/../Models/Spectre/l65ll_v181.lib.scs" section=tt_ll_ncap33
include "/usr/pack/umc-65-kgf/umc/ll/tech/Designkits/Cadence_6.1/B11_PB/umc65ll/../Models/Spectre/l65ll_v181.lib.scs" section=tt_ll_pcap12
include "/usr/pack/umc-65-kgf/umc/ll/tech/Designkits/Cadence_6.1/B11_PB/umc65ll/../Models/Spectre/l65ll_v181.lib.scs" section=tt_ll_pcap18
include "/usr/pack/umc-65-kgf/umc/ll/tech/Designkits/Cadence_6.1/B11_PB/umc65ll/../Models/Spectre/l65ll_v181.lib.scs" section=tt_ll_pcap25
include "/usr/pack/umc-65-kgf/umc/ll/tech/Designkits/Cadence_6.1/B11_PB/umc65ll/../Models/Spectre/l65ll_v181.lib.scs" section=tt_ll_pcap33
include "/usr/pack/umc-65-kgf/umc/ll/tech/Designkits/Cadence_6.1/B11_PB/umc65ll/../Models/Spectre/l65ll_v181.lib.scs" section=tt_ll_res
include "/usr/pack/umc-65-kgf/umc/ll/tech/Designkits/Cadence_6.1/B11_PB/umc65ll/../Models/Spectre/L65LL_RVT12_V101_RF.lib.scs" section=tt
include "/usr/pack/umc-65-kgf/umc/ll/tech/Designkits/Cadence_6.1/B11_PB/umc65ll/../Models/Spectre/L65LL_HVT12_V101_RF.lib.scs" section=tt
include "/usr/pack/umc-65-kgf/umc/ll/tech/Designkits/Cadence_6.1/B11_PB/umc65ll/../Models/Spectre/L65LL_LVT12_V101_RF.lib.scs" section=tt
include "/usr/pack/umc-65-kgf/umc/ll/tech/Designkits/Cadence_6.1/B11_PB/umc65ll/../Models/Spectre/L65LL_IO18_V101_RF.lib.scs" section=tt
include "/usr/pack/umc-65-kgf/umc/ll/tech/Designkits/Cadence_6.1/B11_PB/umc65ll/../Models/Spectre/L65LL_IO25_V101_RF.lib.scs" section=tt
include "/usr/pack/umc-65-kgf/umc/ll/tech/Designkits/Cadence_6.1/B11_PB/umc65ll/../Models/Spectre/L65LL_IO33_V111_RF.lib.scs" section=tt
include "/usr/pack/umc-65-kgf/umc/ll/tech/Designkits/Cadence_6.1/B11_PB/umc65ll/../Models/Spectre/L65LL_VARMIS12_V111_RF.lib.scs" section=typ
include "/usr/pack/umc-65-kgf/umc/ll/tech/Designkits/Cadence_6.1/B11_PB/umc65ll/../Models/Spectre/L65LL_VARMIS18_V111_RF.lib.scs" section=typ
include "/usr/pack/umc-65-kgf/umc/ll/tech/Designkits/Cadence_6.1/B11_PB/umc65ll/../Models/Spectre/L65LL_VARMIS25_V121_RF.lib.scs" section=typ
include "/usr/pack/umc-65-kgf/umc/ll/tech/Designkits/Cadence_6.1/B11_PB/umc65ll/../Models/Spectre/L65LL_VARMIS33_V111_RF.lib.scs" section=typ
include "/usr/pack/umc-65-kgf/umc/ll/tech/Designkits/Cadence_6.1/B11_PB/umc65ll/../Models/Spectre/L65LL_VARDIOP_V101_RF.lib.scs" section=typ
include "/usr/pack/umc-65-kgf/umc/ll/tech/Designkits/Cadence_6.1/B11_PB/umc65ll/../Models/Spectre/momcaps_array_vp3_rfvcl_V101.lib.scs" section=typ
include "/usr/pack/umc-65-kgf/umc/ll/tech/Designkits/Cadence_6.1/B11_PB/umc65ll/../Models/Spectre/momcaps_array_vp4_rfvcl_V101.lib.scs" section=typ
include "/usr/pack/umc-65-kgf/umc/ll/tech/Designkits/Cadence_6.1/B11_PB/umc65ll/../Models/Spectre/momcaps_array_vp5_rfvcl_V101.lib.scs" section=typ
include "/usr/pack/umc-65-kgf/umc/ll/tech/Designkits/Cadence_6.1/B11_PB/umc65ll/../Models/Spectre/L65_MIMCAPS_20F_KF_V101_RF.lib.scs" section=tt
include "/usr/pack/umc-65-kgf/umc/ll/tech/Designkits/Cadence_6.1/B11_PB/umc65ll/../Models/Spectre/L65LL_RNPPO_V101_RF.lib.scs" section=typ
include "/usr/pack/umc-65-kgf/umc/ll/tech/Designkits/Cadence_6.1/B11_PB/umc65ll/../Models/Spectre/L65LL_RNNPO_V101_RF.lib.scs" section=typ
include "/usr/pack/umc-65-kgf/umc/ll/tech/Designkits/Cadence_6.1/B11_PB/umc65ll/../Models/Spectre/L65LL_RNHR_V101_RF.lib.scs" section=typ
include "/usr/pack/umc-65-kgf/umc/ll/tech/Designkits/Cadence_6.1/B11_PB/umc65ll/../Models/Spectre/L65_pad_rf_V101.lib.scs" section=typ
include "/usr/pack/umc-65-kgf/umc/ll/tech/Designkits/Cadence_6.1/B11_PB/umc65ll/../Models/Spectre/VIL/1P8M1T1U/l_sy30k_vil_V111_RF.lib.scs" section=typ
include "/usr/pack/umc-65-kgf/umc/ll/tech/Designkits/Cadence_6.1/B11_PB/umc65ll/../Models/Spectre/VIL/1P8M1T1U/l_syct30k_vil_V111_RF.lib.scs" section=typ
include "/usr/pack/umc-65-kgf/umc/ll/tech/Designkits/Cadence_6.1/B11_PB/umc65ll/../Models/Spectre/VIL/1P8M1T1U/l_slcr30k_vil_V111_RF.lib.scs" section=typ
include "/usr/pack/umc-65-kgf/umc/ll/tech/Designkits/Cadence_6.1/B11_PB/umc65ll/../Models/Spectre/VIL/1P8M1T1U/l_sqsk_vil_V111_RF.lib.scs" section=typ
include "/usr/pack/umc-65-kgf/umc/ll/tech/Designkits/Cadence_6.1/B11_PB/umc65ll/../Models/Spectre/VTL/1P8M1T1U/l_occtout_trans_rfvil_V101.lib.scs" section=typ
include "/usr/pack/umc-65-kgf/umc/ll/tech/Designkits/Cadence_6.1/B11_PB/umc65ll/../Models/Spectre/VTL/1P8M1T1U/l_sq_trans_rfvil_V101.lib.scs" section=typ
include "/usr/pack/umc-65-kgf/umc/ll/tech/Designkits/Cadence_6.1/B11_PB/umc65ll/../Models/Spectre/VTL/1P8M1T1U/l_sqctin_trans_rfvil_V101.lib.scs" section=typ
include "/usr/pack/umc-65-kgf/umc/ll/tech/Designkits/Cadence_6.1/B11_PB/umc65ll/../Models/Spectre/VTL/1P8M1T1U/l_sqctinout_trans_rfvil_V101.lib.scs" section=typ
include "/usr/pack/umc-65-kgf/umc/ll/tech/Designkits/Cadence_6.1/B11_PB/umc65ll/../Models/Spectre/VTL/1P8M1T1U/l_sqctout_trans_rfvil_V101.lib.scs" section=typ
