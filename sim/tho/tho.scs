// /home/msc16f2/potstill/templates/..
include "/home/msc16f2/potstill/templates/../sim/preamble.scs"
include "PS4X8.cir"
X (CK RE RA RA RD0 RD1 RD2 RD3 RD4 RD5 RD6 RD7 WE WA WA WD WD WD WD WD WD WD WD VDD 0) PS4X8
parameters tsc=230p tsd=230p tinit=4e-10 tdr=-5.55556e-11
VDD (VDD 0) vsource type=dc dc=1.2
VCK0 (nCK1 0) vsource type=pulse val0=0 val1=1.2 delay=3e-09 width=1e-09 period=4e-09
VCK1 (CK nCK1) vsource type=pulse val0=0 val1=1.2 delay=1e-09-0.5*tsc width=1e-09-0.5*tsc period=4e-09 rise=tsc fall=10p
VRE0 (nRE1 0) vsource type=pulse val0=0 val1=1.2 delay=1e-09-0.5*tsd-(3.58486e-11) width=6e-09-tsd+(3.58486e-11) period=1.6e-08 rise=tsd fall=tsd
VRE1 (nRE2 nRE1) vsource type=pulse val0=0 val1=1.2 delay=7e-09-0.5*tsd width=6e-09-tsd-(6.31213e-11) period=1.6e-08 rise=tsd fall=tsd
VRE2 (nRE3 nRE2) vsource type=pulse rise=tsd fall=10p val0=0 val1=-(1.2) delay=1e-09+tinit-0.5*tsd width=1e-09-tinit-0.5*tsd-5p period=1.6e-08+tdr
VRE3 (RE nRE3) vsource type=pulse rise=tsd fall=10p val0=0 val1=1.2 delay=1.3e-08+tinit-0.5*tsd width=1e-09-tinit-0.5*tsd-5p period=1.6e-08+tdr
VWE0 (nWE1 0) vsource type=pulse val0=0 val1=1.2 delay=1e-09-0.5*tsd-(3.58486e-11) width=6e-09-tsd+(3.58486e-11) period=1.6e-08 rise=tsd fall=tsd
VWE1 (nWE2 nWE1) vsource type=pulse val0=0 val1=1.2 delay=7e-09-0.5*tsd width=6e-09-tsd-(6.31213e-11) period=1.6e-08 rise=tsd fall=tsd
VWE2 (nWE3 nWE2) vsource type=pulse rise=tsd fall=10p val0=0 val1=-(1.2) delay=1e-09+tinit-0.5*tsd width=1e-09-tinit-0.5*tsd-5p period=1.6e-08+tdr
VWE3 (WE nWE3) vsource type=pulse rise=tsd fall=10p val0=0 val1=1.2 delay=1.3e-08+tinit-0.5*tsd width=1e-09-tinit-0.5*tsd-5p period=1.6e-08+tdr
VRA0 (nRA1 0) vsource type=pulse val0=0 val1=1.2 delay=5e-09-0.5*tsd-(-3.38483e-11) width=2e-09-tsd+(-3.38483e-11) period=1.6e-08 rise=tsd fall=tsd
VRA1 (nRA2 nRA1) vsource type=pulse val0=0 val1=1.2 delay=7e-09-0.5*tsd width=2e-09-tsd-(-3.0818e-11) period=1.6e-08 rise=tsd fall=tsd
VRA2 (nRA3 nRA2) vsource type=pulse rise=tsd fall=10p val0=0 val1=-(1.2) delay=5e-09+tinit-0.5*tsd width=1e-09-tinit-0.5*tsd-5p period=1.6e-08+tdr
VRA3 (RA nRA3) vsource type=pulse rise=tsd fall=10p val0=0 val1=1.2 delay=9e-09+tinit-0.5*tsd width=1e-09-tinit-0.5*tsd-5p period=1.6e-08+tdr
VWA0 (nWA1 0) vsource type=pulse val0=0 val1=1.2 delay=5e-09-0.5*tsd-(-6.41513e-11) width=2e-09-tsd+(-6.41513e-11) period=1.6e-08 rise=tsd fall=tsd
VWA1 (nWA2 nWA1) vsource type=pulse val0=0 val1=1.2 delay=7e-09-0.5*tsd width=2e-09-tsd-(-1.56665e-11) period=1.6e-08 rise=tsd fall=tsd
VWA2 (nWA3 nWA2) vsource type=pulse rise=tsd fall=10p val0=0 val1=-(1.2) delay=5e-09+tinit-0.5*tsd width=1e-09-tinit-0.5*tsd-5p period=1.6e-08+tdr
VWA3 (WA nWA3) vsource type=pulse rise=tsd fall=10p val0=0 val1=1.2 delay=9e-09+tinit-0.5*tsd width=1e-09-tinit-0.5*tsd-5p period=1.6e-08+tdr
VWD0 (nWD1 0) vsource type=pulse val0=0 val1=1.2 delay=5e-09-0.5*tsd-(-1.86968e-11) width=2e-09-tsd+(-1.86968e-11) period=1.6e-08 rise=tsd fall=tsd
VWD1 (nWD2 nWD1) vsource type=pulse val0=0 val1=1.2 delay=7e-09-0.5*tsd width=2e-09-tsd-(-5.20301e-11) period=1.6e-08 rise=tsd fall=tsd
VWD2 (nWD3 nWD2) vsource type=pulse rise=tsd fall=10p val0=0 val1=-(1.2) delay=5e-09+tinit-0.5*tsd width=1e-09-tinit-0.5*tsd-5p period=1.6e-08+tdr
VWD3 (WD nWD3) vsource type=pulse rise=tsd fall=10p val0=0 val1=1.2 delay=9e-09+tinit-0.5*tsd width=1e-09-tinit-0.5*tsd-5p period=1.6e-08+tdr
tran tran stop=1.61e-07 readns="PS4X8.ns"
save CK RE WE WA RA WD
save X.XRWCKG.X0.n1 X.nRA0 X.XRWCKG.X1.n1 X.XAD.XCKG0.n1 X.nWD0
