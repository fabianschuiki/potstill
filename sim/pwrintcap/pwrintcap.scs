// /home/msc16f2/potstill/templates/..
include "/home/msc16f2/potstill/templates/../sim/preamble.scs"
include "PS4X8.cir"
X (CK RE RA0 RA1 RD0 RD1 RD2 RD3 RD4 RD5 RD6 RD7 WE WA0 WA1 WD0 WD1 WD2 WD3 WD4 WD5 WD6 WD7 VDD 0) PS4X8
parameters tslew=30p
VDD (VDD 0) vsource type=dc dc=1.2
V0 (CK 0) vsource type=pulse val0=0 val1=1.2 delay=1n width=1n-tslew rise=tslew fall=tslew
V1 (RE 0) vsource type=pulse val0=0 val1=1.2 delay=3n width=1n-tslew rise=tslew fall=tslew
V2 (WE 0) vsource type=pulse val0=0 val1=1.2 delay=5n width=1n-tslew rise=tslew fall=tslew
V3 (RA0 0) vsource type=pulse val0=0 val1=1.2 delay=7n width=1n-tslew rise=tslew fall=tslew
V4 (RA1 0) vsource type=pulse val0=0 val1=1.2 delay=9n width=1n-tslew rise=tslew fall=tslew
V5 (WA0 0) vsource type=pulse val0=0 val1=1.2 delay=11n width=1n-tslew rise=tslew fall=tslew
V6 (WA1 0) vsource type=pulse val0=0 val1=1.2 delay=13n width=1n-tslew rise=tslew fall=tslew
V7 (WD0 0) vsource type=pulse val0=0 val1=1.2 delay=15n width=1n-tslew rise=tslew fall=tslew
V8 (WD1 0) vsource type=pulse val0=0 val1=1.2 delay=17n width=1n-tslew rise=tslew fall=tslew
V9 (WD2 0) vsource type=pulse val0=0 val1=1.2 delay=19n width=1n-tslew rise=tslew fall=tslew
V10 (WD3 0) vsource type=pulse val0=0 val1=1.2 delay=21n width=1n-tslew rise=tslew fall=tslew
V11 (WD4 0) vsource type=pulse val0=0 val1=1.2 delay=23n width=1n-tslew rise=tslew fall=tslew
V12 (WD5 0) vsource type=pulse val0=0 val1=1.2 delay=25n width=1n-tslew rise=tslew fall=tslew
V13 (WD6 0) vsource type=pulse val0=0 val1=1.2 delay=27n width=1n-tslew rise=tslew fall=tslew
V14 (WD7 0) vsource type=pulse val0=0 val1=1.2 delay=29n width=1n-tslew rise=tslew fall=tslew
tran tran stop=31n errpreset=conservative readns="PS4X8.ns"
save VDD:p
save CK RE WE
save RA* depth=1
save WA* depth=1
save WD* depth=1
save X:CK X:RE X:WE X:RA0 X:RA1 X:WA0 X:WA1 X:WD0 X:WD1 X:WD2 X:WD3 X:WD4 X:WD5 X:WD6 X:WD7
