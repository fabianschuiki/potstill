// /home/msc16f2/potstill/templates/..
include "/home/msc16f2/potstill/templates/../sim/preamble.scs"
include "PS4X8.cir"
X (CK B A A RD0 RD1 RD2 RD3 RD4 RD5 RD6 RD7 B A A A A A A A A A A VDD 0) PS4X8
parameters tsc=230p tsd=230p tinit=-1.5e-10 tdr=3.0303e-12
VDD (VDD 0) vsource type=dc dc=1.2
VCK0 (nCK1 0) vsource type=pulse val0=0 val1=1.2 delay=3n width=1n period=4n
VCK1 (CK nCK1) vsource type=pulse val0=0 val1=1.2 delay=1n-0.5*tsc width=1n-0.5*tsc period=4n rise=tsc fall=10p
VA0 (A 0) vsource type=pulse val0=0 val1=1.2 delay=5n-0.5*tsd+tinit width=4n-tsd period=16n+tdr rise=tsd fall=tsd
VB0 (B 0) vsource type=pulse val0=0 val1=1.2 delay=1n-0.5*tsd+tinit width=12n-tsd period=16n+tdr rise=tsd fall=tsd
tran tran stop=1601n readns="PS4X8.ns"
save CK A B
save X.XRWCKG.X0.n1 X.nRA0 X.XRWCKG.X1.n1 X.XAD.XCKG0.n1 X.nWD0
