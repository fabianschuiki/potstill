// Copyright (c) 2016 Fabian Schuiki
// Spectre simulation to verify operation of the PSBA4 cell.
include "../preamble.scs"

// Netlist of the circuit under test.
include "../../umc65/netlists/components.cir"
include "PSBA4.cir"

// Parameters.
parameters tslew=30p

// Circuit under test.
X (D S0 GP0 GN0 S1 GP1 GN1 S2 GP2 GN2 S3 GP3 GN3 Q VDD 0) PSBA4

VG0P (GP0 0) vsource type=pulse val0=0 val1=1.2 delay=1n width=1n-tslew period=8n rise=tslew fall=tslew
VG0N (GN0 0) vsource type=pulse val1=0 val0=1.2 delay=1n width=1n-tslew period=8n rise=tslew fall=tslew
VG1P (GP1 0) vsource type=pulse val0=0 val1=1.2 delay=3n width=1n-tslew period=8n rise=tslew fall=tslew
VG1N (GN1 0) vsource type=pulse val1=0 val0=1.2 delay=3n width=1n-tslew period=8n rise=tslew fall=tslew
VG2P (GP2 0) vsource type=pulse val0=0 val1=1.2 delay=5n width=1n-tslew period=8n rise=tslew fall=tslew
VG2N (GN2 0) vsource type=pulse val1=0 val0=1.2 delay=5n width=1n-tslew period=8n rise=tslew fall=tslew
VG3P (GP3 0) vsource type=pulse val0=0 val1=1.2 delay=7n width=1n-tslew period=8n rise=tslew fall=tslew
VG3N (GN3 0) vsource type=pulse val1=0 val0=1.2 delay=7n width=1n-tslew period=8n rise=tslew fall=tslew

VS0 (S0 0) vsource type=pulse val0=0 val1=1.2 delay=8n  width=2n-tslew period=8n rise=tslew fall=tslew
VS1 (S1 0) vsource type=pulse val0=0 val1=1.2 delay=10n width=2n-tslew period=8n rise=tslew fall=tslew
VS2 (S2 0) vsource type=pulse val0=0 val1=1.2 delay=12n width=2n-tslew period=8n rise=tslew fall=tslew
VS3 (S3 0) vsource type=pulse val0=0 val1=1.2 delay=14n width=2n-tslew period=8n rise=tslew fall=tslew

V0 (D 0) vsource type=pulse val0=0 val1=1.2 delay=8n rise=tslew fall=tslew

VDD (VDD 0) vsource type=dc dc=1.2

// Specify analysis.
A tran stop=25n errpreset=conservative write="spectre.ic" writefinal="spectre.fc"

// Specify what to save.
save VDD:p
save D
save GP* depth=1
save GN* depth=1
save S* depth=1
save Q
