// Automatically generated SPECTRE input file.
// PS4X128
include "/home/msc16f2/potstill/templates/../sim/preamble.scs"
include "PS4X128.cir"
X (CK RE RA0 RA1 RD0 RD1 RD2 RD3 RD4 RD5 RD6 RD7 RD8 RD9 RD10 RD11 RD12 RD13 RD14 RD15 RD16 RD17 RD18 RD19 RD20 RD21 RD22 RD23 RD24 RD25 RD26 RD27 RD28 RD29 RD30 RD31 RD32 RD33 RD34 RD35 RD36 RD37 RD38 RD39 RD40 RD41 RD42 RD43 RD44 RD45 RD46 RD47 RD48 RD49 RD50 RD51 RD52 RD53 RD54 RD55 RD56 RD57 RD58 RD59 RD60 RD61 RD62 RD63 RD64 RD65 RD66 RD67 RD68 RD69 RD70 RD71 RD72 RD73 RD74 RD75 RD76 RD77 RD78 RD79 RD80 RD81 RD82 RD83 RD84 RD85 RD86 RD87 RD88 RD89 RD90 RD91 RD92 RD93 RD94 RD95 RD96 RD97 RD98 RD99 RD100 RD101 RD102 RD103 RD104 RD105 RD106 RD107 RD108 RD109 RD110 RD111 RD112 RD113 RD114 RD115 RD116 RD117 RD118 RD119 RD120 RD121 RD122 RD123 RD124 RD125 RD126 RD127 WE WA0 WA1 WD0 WD1 WD2 WD3 WD4 WD5 WD6 WD7 WD8 WD9 WD10 WD11 WD12 WD13 WD14 WD15 WD16 WD17 WD18 WD19 WD20 WD21 WD22 WD23 WD24 WD25 WD26 WD27 WD28 WD29 WD30 WD31 WD32 WD33 WD34 WD35 WD36 WD37 WD38 WD39 WD40 WD41 WD42 WD43 WD44 WD45 WD46 WD47 WD48 WD49 WD50 WD51 WD52 WD53 WD54 WD55 WD56 WD57 WD58 WD59 WD60 WD61 WD62 WD63 WD64 WD65 WD66 WD67 WD68 WD69 WD70 WD71 WD72 WD73 WD74 WD75 WD76 WD77 WD78 WD79 WD80 WD81 WD82 WD83 WD84 WD85 WD86 WD87 WD88 WD89 WD90 WD91 WD92 WD93 WD94 WD95 WD96 WD97 WD98 WD99 WD100 WD101 WD102 WD103 WD104 WD105 WD106 WD107 WD108 WD109 WD110 WD111 WD112 WD113 WD114 WD115 WD116 WD117 WD118 WD119 WD120 WD121 WD122 WD123 WD124 WD125 WD126 WD127 VDD 0) PS4X128
parameters tslew=30p
VDD (VDD 0) vsource type=dc dc=1.2
VCK (CK 0) vsource type=pulse val0=0 val1=1.2 delay=1n width=1n-tslew period=3n rise=tslew fall=tslew
VRE (RE 0) vsource type=pulse val0=0 val1=1.2 delay=3n width=12n-tslew period=24n rise=tslew fall=tslew
VWE (WE 0) vsource type=pulse val0=0 val1=1.2 delay=15n width=24n-tslew rise=tslew fall=tslew
VWA0 (WA0 0) vsource type=pulse val0=0 val1=1.2 delay=6n width=3n-tslew period=6n rise=tslew fall=tslew
VWA1 (WA1 0) vsource type=pulse val0=0 val1=1.2 delay=9n width=6n-tslew period=12n rise=tslew fall=tslew
VRA0 (RA0 0) vsource type=dc dc=0
VRA1 (RA1 0) vsource type=dc dc=0
VWD0 (WD0 0) vsource type=dc dc=0
VWD1 (WD1 0) vsource type=dc dc=0
VWD2 (WD2 0) vsource type=dc dc=0
VWD3 (WD3 0) vsource type=dc dc=0
VWD4 (WD4 0) vsource type=dc dc=0
VWD5 (WD5 0) vsource type=dc dc=0
VWD6 (WD6 0) vsource type=dc dc=0
VWD7 (WD7 0) vsource type=dc dc=0
VWD8 (WD8 0) vsource type=dc dc=0
VWD9 (WD9 0) vsource type=dc dc=0
VWD10 (WD10 0) vsource type=dc dc=0
VWD11 (WD11 0) vsource type=dc dc=0
VWD12 (WD12 0) vsource type=dc dc=0
VWD13 (WD13 0) vsource type=dc dc=0
VWD14 (WD14 0) vsource type=dc dc=0
VWD15 (WD15 0) vsource type=dc dc=0
VWD16 (WD16 0) vsource type=dc dc=0
VWD17 (WD17 0) vsource type=dc dc=0
VWD18 (WD18 0) vsource type=dc dc=0
VWD19 (WD19 0) vsource type=dc dc=0
VWD20 (WD20 0) vsource type=dc dc=0
VWD21 (WD21 0) vsource type=dc dc=0
VWD22 (WD22 0) vsource type=dc dc=0
VWD23 (WD23 0) vsource type=dc dc=0
VWD24 (WD24 0) vsource type=dc dc=0
VWD25 (WD25 0) vsource type=dc dc=0
VWD26 (WD26 0) vsource type=dc dc=0
VWD27 (WD27 0) vsource type=dc dc=0
VWD28 (WD28 0) vsource type=dc dc=0
VWD29 (WD29 0) vsource type=dc dc=0
VWD30 (WD30 0) vsource type=dc dc=0
VWD31 (WD31 0) vsource type=dc dc=0
VWD32 (WD32 0) vsource type=dc dc=0
VWD33 (WD33 0) vsource type=dc dc=0
VWD34 (WD34 0) vsource type=dc dc=0
VWD35 (WD35 0) vsource type=dc dc=0
VWD36 (WD36 0) vsource type=dc dc=0
VWD37 (WD37 0) vsource type=dc dc=0
VWD38 (WD38 0) vsource type=dc dc=0
VWD39 (WD39 0) vsource type=dc dc=0
VWD40 (WD40 0) vsource type=dc dc=0
VWD41 (WD41 0) vsource type=dc dc=0
VWD42 (WD42 0) vsource type=dc dc=0
VWD43 (WD43 0) vsource type=dc dc=0
VWD44 (WD44 0) vsource type=dc dc=0
VWD45 (WD45 0) vsource type=dc dc=0
VWD46 (WD46 0) vsource type=dc dc=0
VWD47 (WD47 0) vsource type=dc dc=0
VWD48 (WD48 0) vsource type=dc dc=0
VWD49 (WD49 0) vsource type=dc dc=0
VWD50 (WD50 0) vsource type=dc dc=0
VWD51 (WD51 0) vsource type=dc dc=0
VWD52 (WD52 0) vsource type=dc dc=0
VWD53 (WD53 0) vsource type=dc dc=0
VWD54 (WD54 0) vsource type=dc dc=0
VWD55 (WD55 0) vsource type=dc dc=0
VWD56 (WD56 0) vsource type=dc dc=0
VWD57 (WD57 0) vsource type=dc dc=0
VWD58 (WD58 0) vsource type=dc dc=0
VWD59 (WD59 0) vsource type=dc dc=0
VWD60 (WD60 0) vsource type=dc dc=0
VWD61 (WD61 0) vsource type=dc dc=0
VWD62 (WD62 0) vsource type=dc dc=0
VWD63 (WD63 0) vsource type=dc dc=0
VWD64 (WD64 0) vsource type=dc dc=0
VWD65 (WD65 0) vsource type=dc dc=0
VWD66 (WD66 0) vsource type=dc dc=0
VWD67 (WD67 0) vsource type=dc dc=0
VWD68 (WD68 0) vsource type=dc dc=0
VWD69 (WD69 0) vsource type=dc dc=0
VWD70 (WD70 0) vsource type=dc dc=0
VWD71 (WD71 0) vsource type=dc dc=0
VWD72 (WD72 0) vsource type=dc dc=0
VWD73 (WD73 0) vsource type=dc dc=0
VWD74 (WD74 0) vsource type=dc dc=0
VWD75 (WD75 0) vsource type=dc dc=0
VWD76 (WD76 0) vsource type=dc dc=0
VWD77 (WD77 0) vsource type=dc dc=0
VWD78 (WD78 0) vsource type=dc dc=0
VWD79 (WD79 0) vsource type=dc dc=0
VWD80 (WD80 0) vsource type=dc dc=0
VWD81 (WD81 0) vsource type=dc dc=0
VWD82 (WD82 0) vsource type=dc dc=0
VWD83 (WD83 0) vsource type=dc dc=0
VWD84 (WD84 0) vsource type=dc dc=0
VWD85 (WD85 0) vsource type=dc dc=0
VWD86 (WD86 0) vsource type=dc dc=0
VWD87 (WD87 0) vsource type=dc dc=0
VWD88 (WD88 0) vsource type=dc dc=0
VWD89 (WD89 0) vsource type=dc dc=0
VWD90 (WD90 0) vsource type=dc dc=0
VWD91 (WD91 0) vsource type=dc dc=0
VWD92 (WD92 0) vsource type=dc dc=0
VWD93 (WD93 0) vsource type=dc dc=0
VWD94 (WD94 0) vsource type=dc dc=0
VWD95 (WD95 0) vsource type=dc dc=0
VWD96 (WD96 0) vsource type=dc dc=0
VWD97 (WD97 0) vsource type=dc dc=0
VWD98 (WD98 0) vsource type=dc dc=0
VWD99 (WD99 0) vsource type=dc dc=0
VWD100 (WD100 0) vsource type=dc dc=0
VWD101 (WD101 0) vsource type=dc dc=0
VWD102 (WD102 0) vsource type=dc dc=0
VWD103 (WD103 0) vsource type=dc dc=0
VWD104 (WD104 0) vsource type=dc dc=0
VWD105 (WD105 0) vsource type=dc dc=0
VWD106 (WD106 0) vsource type=dc dc=0
VWD107 (WD107 0) vsource type=dc dc=0
VWD108 (WD108 0) vsource type=dc dc=0
VWD109 (WD109 0) vsource type=dc dc=0
VWD110 (WD110 0) vsource type=dc dc=0
VWD111 (WD111 0) vsource type=dc dc=0
VWD112 (WD112 0) vsource type=dc dc=0
VWD113 (WD113 0) vsource type=dc dc=0
VWD114 (WD114 0) vsource type=dc dc=0
VWD115 (WD115 0) vsource type=dc dc=0
VWD116 (WD116 0) vsource type=dc dc=0
VWD117 (WD117 0) vsource type=dc dc=0
VWD118 (WD118 0) vsource type=dc dc=0
VWD119 (WD119 0) vsource type=dc dc=0
VWD120 (WD120 0) vsource type=dc dc=0
VWD121 (WD121 0) vsource type=dc dc=0
VWD122 (WD122 0) vsource type=dc dc=0
VWD123 (WD123 0) vsource type=dc dc=0
VWD124 (WD124 0) vsource type=dc dc=0
VWD125 (WD125 0) vsource type=dc dc=0
VWD126 (WD126 0) vsource type=dc dc=0
VWD127 (WD127 0) vsource type=dc dc=0
tran tran stop=40n errpreset=conservative readns="PS4X128.ns"
save VDD:p
