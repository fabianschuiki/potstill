openResults("./tsu.psf")
selectResult('tran)
p = outfile("tsu.csv", "w")
X_RE_rise = cross(VT("X.XRWCKG.X0.n1") 0.6 1 "falling" t "cycle")
X_RE_fall = cross(VT("X.XRWCKG.X0.n1") 0.6 1 "rising" t "cycle")
X_WE_rise = cross(VT("X.XRWCKG.X1.n1") 0.6 1 "falling" t "cycle")
X_WE_fall = cross(VT("X.XRWCKG.X1.n1") 0.6 1 "rising" t "cycle")
X_RA_rise = cross(VT("X.nRA0") 0.6 1 "rising" t "cycle")
X_RA_fall = cross(VT("X.nRA0") 0.6 1 "falling" t "cycle")
X_WA_rise = cross(VT("X.XAD.XCKG0.n1") 0.6 1 "rising" t "cycle")
X_WA_fall = cross(VT("X.XAD.XCKG0.n1") 0.6 1 "falling" t "cycle")
X_WD_rise = cross(VT("X.nWD0") 0.6 1 "rising" t "cycle")
X_WD_fall = cross(VT("X.nWD0") 0.6 1 "falling" t "cycle")
X_A_rise = cross(VT("A") 0.6 1 "rising" t "cycle")
X_A_fall = cross(VT("A") 0.6 1 "falling" t "cycle")
X_B_rise = cross(VT("B") 0.6 1 "rising" t "cycle")
X_B_fall = cross(VT("B") 0.6 1 "falling" t "cycle")
Tpd_WA_rise = (X_WA_rise - X_A_rise)
Tpd_WA_fall = (X_WA_fall - X_A_fall)
Tpd_RE_rise = (X_RE_rise - X_B_rise)
Tpd_RE_fall = (X_RE_fall - X_B_fall)
Tpd_WE_rise = (X_WE_rise - X_B_rise)
Tpd_WE_fall = (X_WE_fall - X_B_fall)
Tpd_RA_rise = (X_RA_rise - int(X_RA_rise / 16n) * 16n - 5n)
Tpd_RA_fall = (X_RA_fall - int(X_RA_rise / 16n) * 16n - 9n)
Tpd_WD_rise = (X_WD_rise - int(X_WD_rise / 16n) * 16n - 5n)
Tpd_WD_fall = (X_WD_fall - int(X_WD_rise / 16n) * 16n - 9n)
Tpdth_RE_rise = value(Tpd_RE_rise 1) * 1.050000
Tpdth_RE_fall = value(Tpd_RE_fall 1) * 1.050000
Tpdth_RA_rise = value(Tpd_RA_rise 1) * 1.050000
Tpdth_RA_fall = value(Tpd_RA_fall 1) * 1.050000
Tpdth_WE_rise = value(Tpd_WE_rise 1) * 1.050000
Tpdth_WE_fall = value(Tpd_WE_fall 1) * 1.050000
Tpdth_WA_rise = value(Tpd_WA_rise 1) * 1.050000
Tpdth_WA_fall = value(Tpd_WA_fall 1) * 1.050000
Tpdth_WD_rise = value(Tpd_WD_rise 1) * 1.050000
Tpdth_WD_fall = value(Tpd_WD_fall 1) * 1.050000
Nc_RE_rise = int(cross(Tpd_RE_rise Tpdth_RE_rise 1 "rising"))
fprintf(p, "Tsu_RE_rise,%g\n", 1.5e-10 - Nc_RE_rise * 3.0303e-12)
Nc_RE_fall = int(cross(Tpd_RE_fall Tpdth_RE_fall 1 "rising"))
fprintf(p, "Tsu_RE_fall,%g\n", 1.5e-10 - Nc_RE_fall * 3.0303e-12)
Nc_RA_rise = int(cross(Tpd_RA_rise Tpdth_RA_rise 1 "rising"))
fprintf(p, "Tsu_RA_rise,%g\n", 1.5e-10 - Nc_RA_rise * 3.0303e-12)
Nc_RA_fall = int(cross(Tpd_RA_fall Tpdth_RA_fall 1 "rising"))
fprintf(p, "Tsu_RA_fall,%g\n", 1.5e-10 - Nc_RA_fall * 3.0303e-12)
Nc_WE_rise = int(cross(Tpd_WE_rise Tpdth_WE_rise 1 "rising"))
fprintf(p, "Tsu_WE_rise,%g\n", 1.5e-10 - Nc_WE_rise * 3.0303e-12)
Nc_WE_fall = int(cross(Tpd_WE_fall Tpdth_WE_fall 1 "rising"))
fprintf(p, "Tsu_WE_fall,%g\n", 1.5e-10 - Nc_WE_fall * 3.0303e-12)
Nc_WA_rise = int(cross(Tpd_WA_rise Tpdth_WA_rise 1 "rising"))
fprintf(p, "Tsu_WA_rise,%g\n", 1.5e-10 - Nc_WA_rise * 3.0303e-12)
Nc_WA_fall = int(cross(Tpd_WA_fall Tpdth_WA_fall 1 "rising"))
fprintf(p, "Tsu_WA_fall,%g\n", 1.5e-10 - Nc_WA_fall * 3.0303e-12)
Nc_WD_rise = int(cross(Tpd_WD_rise Tpdth_WD_rise 1 "rising"))
fprintf(p, "Tsu_WD_rise,%g\n", 1.5e-10 - Nc_WD_rise * 3.0303e-12)
Nc_WD_fall = int(cross(Tpd_WD_fall Tpdth_WD_fall 1 "rising"))
fprintf(p, "Tsu_WD_fall,%g\n", 1.5e-10 - Nc_WD_fall * 3.0303e-12)
close(p)
exit
