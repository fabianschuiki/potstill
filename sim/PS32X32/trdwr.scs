// /home/msc16f2/potstill/templates/..
include "/home/msc16f2/potstill/templates/../sim/preamble.scs"
include "PS32X32.cir"
X (CK RE VDD VDD VDD VDD VDD RD0 RD1 RD2 RD3 RD4 RD5 RD6 RD7 RD8 RD9 RD10 RD11 RD12 RD13 RD14 RD15 RD16 RD17 RD18 RD19 RD20 RD21 RD22 RD23 RD24 RD25 RD26 RD27 RD28 RD29 RD30 RD31 WE VDD VDD VDD VDD VDD VDD VDD VDD VDD VDD VDD VDD VDD VDD VDD VDD VDD VDD VDD VDD VDD VDD VDD VDD VDD VDD VDD VDD VDD VDD VDD VDD VDD VDD VDD VDD VDD VDD 0) PS32X32
C0 (RD0 0) capacitor c=cload

C1 (RD1 0) capacitor c=cload

C2 (RD2 0) capacitor c=cload

C3 (RD3 0) capacitor c=cload

C4 (RD4 0) capacitor c=cload

C5 (RD5 0) capacitor c=cload

C6 (RD6 0) capacitor c=cload

C7 (RD7 0) capacitor c=cload

C8 (RD8 0) capacitor c=cload

C9 (RD9 0) capacitor c=cload

C10 (RD10 0) capacitor c=cload

C11 (RD11 0) capacitor c=cload

C12 (RD12 0) capacitor c=cload

C13 (RD13 0) capacitor c=cload

C14 (RD14 0) capacitor c=cload

C15 (RD15 0) capacitor c=cload

C16 (RD16 0) capacitor c=cload

C17 (RD17 0) capacitor c=cload

C18 (RD18 0) capacitor c=cload

C19 (RD19 0) capacitor c=cload

C20 (RD20 0) capacitor c=cload

C21 (RD21 0) capacitor c=cload

C22 (RD22 0) capacitor c=cload

C23 (RD23 0) capacitor c=cload

C24 (RD24 0) capacitor c=cload

C25 (RD25 0) capacitor c=cload

C26 (RD26 0) capacitor c=cload

C27 (RD27 0) capacitor c=cload

C28 (RD28 0) capacitor c=cload

C29 (RD29 0) capacitor c=cload

C30 (RD30 0) capacitor c=cload

C31 (RD31 0) capacitor c=cload

parameters tslew=30p cload=1e-20

VDD (VDD 0) vsource type=dc dc=1.2
VCK (CK 0) vsource type=pulse val0=0 val1=1.2 delay=1n width=1n-tslew period=3n rise=tslew fall=tslew
VWE (WE 0) vsource type=pulse val0=1.2 val1=0 delay=3n rise=tslew fall=tslew
VRE (RE 0) vsource type=pulse val0=0 val1=1.2 delay=3n rise=tslew fall=tslew
tran tran stop=6n errpreset=conservative readns="PS32X32.ns"
save CK RE WE
save RD* depth=1
save X.XBA*.X31.nZ
