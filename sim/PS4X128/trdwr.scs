// /home/msc16f2/potstill/templates/..
include "/home/msc16f2/potstill/templates/../sim/preamble.scs"
include "PS4X128.cir"
X (CK RE VDD VDD RD0 RD1 RD2 RD3 RD4 RD5 RD6 RD7 RD8 RD9 RD10 RD11 RD12 RD13 RD14 RD15 RD16 RD17 RD18 RD19 RD20 RD21 RD22 RD23 RD24 RD25 RD26 RD27 RD28 RD29 RD30 RD31 RD32 RD33 RD34 RD35 RD36 RD37 RD38 RD39 RD40 RD41 RD42 RD43 RD44 RD45 RD46 RD47 RD48 RD49 RD50 RD51 RD52 RD53 RD54 RD55 RD56 RD57 RD58 RD59 RD60 RD61 RD62 RD63 RD64 RD65 RD66 RD67 RD68 RD69 RD70 RD71 RD72 RD73 RD74 RD75 RD76 RD77 RD78 RD79 RD80 RD81 RD82 RD83 RD84 RD85 RD86 RD87 RD88 RD89 RD90 RD91 RD92 RD93 RD94 RD95 RD96 RD97 RD98 RD99 RD100 RD101 RD102 RD103 RD104 RD105 RD106 RD107 RD108 RD109 RD110 RD111 RD112 RD113 RD114 RD115 RD116 RD117 RD118 RD119 RD120 RD121 RD122 RD123 RD124 RD125 RD126 RD127 WE VDD VDD VDD VDD VDD VDD VDD VDD VDD VDD VDD VDD VDD VDD VDD VDD VDD VDD VDD VDD VDD VDD VDD VDD VDD VDD VDD VDD VDD VDD VDD VDD VDD VDD VDD VDD VDD VDD VDD VDD VDD VDD VDD VDD VDD VDD VDD VDD VDD VDD VDD VDD VDD VDD VDD VDD VDD VDD VDD VDD VDD VDD VDD VDD VDD VDD VDD VDD VDD VDD VDD VDD VDD VDD VDD VDD VDD VDD VDD VDD VDD VDD VDD VDD VDD VDD VDD VDD VDD VDD VDD VDD VDD VDD VDD VDD VDD VDD VDD VDD VDD VDD VDD VDD VDD VDD VDD VDD VDD VDD VDD VDD VDD VDD VDD VDD VDD VDD VDD VDD VDD VDD VDD VDD VDD VDD VDD VDD VDD VDD VDD 0) PS4X128
parameters tslew=30p
VDD (VDD 0) vsource type=dc dc=1.2
VCK (CK 0) vsource type=pulse val0=0 val1=1.2 delay=1n width=1n-tslew period=3n rise=tslew fall=tslew
VWE (WE 0) vsource type=pulse val0=1.2 val1=0 delay=3n rise=tslew fall=tslew
VRE (RE 0) vsource type=pulse val0=0 val1=1.2 delay=3n rise=tslew fall=tslew
tran tran stop=6n errpreset=conservative readns="PS4X128.ns"
save CK RE WE
save RD* depth=1
save X.XBA*.X3.nZ
