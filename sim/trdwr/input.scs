// /home/msc16f2/potstill/templates/..
include "/home/msc16f2/potstill/templates/../sim/preamble.scs"
include "PS4X8.cir"
X (CK RE VDD VDD RD0 RD1 RD2 RD3 RD4 RD5 RD6 RD7 WE VDD VDD VDD VDD VDD VDD VDD VDD VDD VDD VDD 0) PS4X8
parameters tslew=30p
VDD (VDD 0) vsource type=dc dc=1.2
VCK (CK 0) vsource type=pulse val0=0 val1=1.2 delay=1n width=1n-tslew period=3n rise=tslew fall=tslew
VWE (WE 0) vsource type=pulse val0=1.2 val1=0 delay=3n rise=tslew fall=tslew
VRE (RE 0) vsource type=pulse val0=0 val1=1.2 delay=3n rise=tslew fall=tslew
tran tran stop=6n errpreset=conservative readns="PS4X8.ns"
save CK RE WE
save RD* depth=1
save X.XBA*.X3.nZ
