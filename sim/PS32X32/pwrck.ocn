openResults("./pwrck.psf")
selectResult('tran)
p = outfile("pwrck.csv", "w")
fprintf(p, "P_leak,%g\n", integ(-IT("VDD:p") 0n 5n) / 5n * 1.2)
fprintf(p, "E_idle_rise,%g\n", integ(-IT("VDD:p") 5n 10n) * 1.2)
fprintf(p, "E_idle_fall,%g\n", integ(-IT("VDD:p") 10n 15n) * 1.2)
fprintf(p, "E_read_rise,%g\n", (integ(-IT("VDD:p") 20n 25n) + integ(-IT("VDD:p") 35n 40n) + integ(-IT("VDD:p") 50n 55n) + integ(-IT("VDD:p") 65n 70n) + integ(-IT("VDD:p") 80n 85n) + integ(-IT("VDD:p") 95n 100n) + integ(-IT("VDD:p") 110n 115n) + integ(-IT("VDD:p") 125n 130n) + integ(-IT("VDD:p") 140n 145n) + integ(-IT("VDD:p") 155n 160n) + integ(-IT("VDD:p") 170n 175n) + integ(-IT("VDD:p") 185n 190n) + integ(-IT("VDD:p") 200n 205n) + integ(-IT("VDD:p") 215n 220n) + integ(-IT("VDD:p") 230n 235n) + integ(-IT("VDD:p") 245n 250n) + integ(-IT("VDD:p") 260n 265n) + integ(-IT("VDD:p") 275n 280n) + integ(-IT("VDD:p") 290n 295n) + integ(-IT("VDD:p") 305n 310n) + integ(-IT("VDD:p") 320n 325n) + integ(-IT("VDD:p") 335n 340n) + integ(-IT("VDD:p") 350n 355n) + integ(-IT("VDD:p") 365n 370n) + integ(-IT("VDD:p") 380n 385n) + integ(-IT("VDD:p") 395n 400n) + integ(-IT("VDD:p") 410n 415n) + integ(-IT("VDD:p") 425n 430n) + integ(-IT("VDD:p") 440n 445n) + integ(-IT("VDD:p") 455n 460n) + integ(-IT("VDD:p") 470n 475n) + integ(-IT("VDD:p") 485n 490n)) / 32 * 1.2)
fprintf(p, "E_read_fall,%g\n", (integ(-IT("VDD:p") 25n 30n) + integ(-IT("VDD:p") 40n 45n) + integ(-IT("VDD:p") 55n 60n) + integ(-IT("VDD:p") 70n 75n) + integ(-IT("VDD:p") 85n 90n) + integ(-IT("VDD:p") 100n 105n) + integ(-IT("VDD:p") 115n 120n) + integ(-IT("VDD:p") 130n 135n) + integ(-IT("VDD:p") 145n 150n) + integ(-IT("VDD:p") 160n 165n) + integ(-IT("VDD:p") 175n 180n) + integ(-IT("VDD:p") 190n 195n) + integ(-IT("VDD:p") 205n 210n) + integ(-IT("VDD:p") 220n 225n) + integ(-IT("VDD:p") 235n 240n) + integ(-IT("VDD:p") 250n 255n) + integ(-IT("VDD:p") 265n 270n) + integ(-IT("VDD:p") 280n 285n) + integ(-IT("VDD:p") 295n 300n) + integ(-IT("VDD:p") 310n 315n) + integ(-IT("VDD:p") 325n 330n) + integ(-IT("VDD:p") 340n 345n) + integ(-IT("VDD:p") 355n 360n) + integ(-IT("VDD:p") 370n 375n) + integ(-IT("VDD:p") 385n 390n) + integ(-IT("VDD:p") 400n 405n) + integ(-IT("VDD:p") 415n 420n) + integ(-IT("VDD:p") 430n 435n) + integ(-IT("VDD:p") 445n 450n) + integ(-IT("VDD:p") 460n 465n) + integ(-IT("VDD:p") 475n 480n) + integ(-IT("VDD:p") 490n 495n)) / 32 * 1.2)
fprintf(p, "E_write_rise,%g\n", (integ(-IT("VDD:p") 500n 505n) + integ(-IT("VDD:p") 515n 520n) + integ(-IT("VDD:p") 530n 535n) + integ(-IT("VDD:p") 545n 550n) + integ(-IT("VDD:p") 560n 565n) + integ(-IT("VDD:p") 575n 580n) + integ(-IT("VDD:p") 590n 595n) + integ(-IT("VDD:p") 605n 610n) + integ(-IT("VDD:p") 620n 625n) + integ(-IT("VDD:p") 635n 640n) + integ(-IT("VDD:p") 650n 655n) + integ(-IT("VDD:p") 665n 670n) + integ(-IT("VDD:p") 680n 685n) + integ(-IT("VDD:p") 695n 700n) + integ(-IT("VDD:p") 710n 715n) + integ(-IT("VDD:p") 725n 730n) + integ(-IT("VDD:p") 740n 745n) + integ(-IT("VDD:p") 755n 760n) + integ(-IT("VDD:p") 770n 775n) + integ(-IT("VDD:p") 785n 790n) + integ(-IT("VDD:p") 800n 805n) + integ(-IT("VDD:p") 815n 820n) + integ(-IT("VDD:p") 830n 835n) + integ(-IT("VDD:p") 845n 850n) + integ(-IT("VDD:p") 860n 865n) + integ(-IT("VDD:p") 875n 880n) + integ(-IT("VDD:p") 890n 895n) + integ(-IT("VDD:p") 905n 910n) + integ(-IT("VDD:p") 920n 925n) + integ(-IT("VDD:p") 935n 940n) + integ(-IT("VDD:p") 950n 955n) + integ(-IT("VDD:p") 965n 970n)) / 32 * 1.2)
fprintf(p, "E_write_fall,%g\n", (integ(-IT("VDD:p") 505n 510n) + integ(-IT("VDD:p") 520n 525n) + integ(-IT("VDD:p") 535n 540n) + integ(-IT("VDD:p") 550n 555n) + integ(-IT("VDD:p") 565n 570n) + integ(-IT("VDD:p") 580n 585n) + integ(-IT("VDD:p") 595n 600n) + integ(-IT("VDD:p") 610n 615n) + integ(-IT("VDD:p") 625n 630n) + integ(-IT("VDD:p") 640n 645n) + integ(-IT("VDD:p") 655n 660n) + integ(-IT("VDD:p") 670n 675n) + integ(-IT("VDD:p") 685n 690n) + integ(-IT("VDD:p") 700n 705n) + integ(-IT("VDD:p") 715n 720n) + integ(-IT("VDD:p") 730n 735n) + integ(-IT("VDD:p") 745n 750n) + integ(-IT("VDD:p") 760n 765n) + integ(-IT("VDD:p") 775n 780n) + integ(-IT("VDD:p") 790n 795n) + integ(-IT("VDD:p") 805n 810n) + integ(-IT("VDD:p") 820n 825n) + integ(-IT("VDD:p") 835n 840n) + integ(-IT("VDD:p") 850n 855n) + integ(-IT("VDD:p") 865n 870n) + integ(-IT("VDD:p") 880n 885n) + integ(-IT("VDD:p") 895n 900n) + integ(-IT("VDD:p") 910n 915n) + integ(-IT("VDD:p") 925n 930n) + integ(-IT("VDD:p") 940n 945n) + integ(-IT("VDD:p") 955n 960n) + integ(-IT("VDD:p") 970n 975n)) / 32 * 1.2)
fprintf(p, "E_rw_rise,%g\n", (integ(-IT("VDD:p") 980n 985n) + integ(-IT("VDD:p") 995n 1000n) + integ(-IT("VDD:p") 1010n 1015n) + integ(-IT("VDD:p") 1025n 1030n) + integ(-IT("VDD:p") 1040n 1045n) + integ(-IT("VDD:p") 1055n 1060n) + integ(-IT("VDD:p") 1070n 1075n) + integ(-IT("VDD:p") 1085n 1090n) + integ(-IT("VDD:p") 1100n 1105n) + integ(-IT("VDD:p") 1115n 1120n) + integ(-IT("VDD:p") 1130n 1135n) + integ(-IT("VDD:p") 1145n 1150n) + integ(-IT("VDD:p") 1160n 1165n) + integ(-IT("VDD:p") 1175n 1180n) + integ(-IT("VDD:p") 1190n 1195n) + integ(-IT("VDD:p") 1205n 1210n) + integ(-IT("VDD:p") 1220n 1225n) + integ(-IT("VDD:p") 1235n 1240n) + integ(-IT("VDD:p") 1250n 1255n) + integ(-IT("VDD:p") 1265n 1270n) + integ(-IT("VDD:p") 1280n 1285n) + integ(-IT("VDD:p") 1295n 1300n) + integ(-IT("VDD:p") 1310n 1315n) + integ(-IT("VDD:p") 1325n 1330n) + integ(-IT("VDD:p") 1340n 1345n) + integ(-IT("VDD:p") 1355n 1360n) + integ(-IT("VDD:p") 1370n 1375n) + integ(-IT("VDD:p") 1385n 1390n) + integ(-IT("VDD:p") 1400n 1405n) + integ(-IT("VDD:p") 1415n 1420n) + integ(-IT("VDD:p") 1430n 1435n) + integ(-IT("VDD:p") 1445n 1450n)) / 32 * 1.2)
fprintf(p, "E_rw_fall,%g\n", (integ(-IT("VDD:p") 985n 990n) + integ(-IT("VDD:p") 1000n 1005n) + integ(-IT("VDD:p") 1015n 1020n) + integ(-IT("VDD:p") 1030n 1035n) + integ(-IT("VDD:p") 1045n 1050n) + integ(-IT("VDD:p") 1060n 1065n) + integ(-IT("VDD:p") 1075n 1080n) + integ(-IT("VDD:p") 1090n 1095n) + integ(-IT("VDD:p") 1105n 1110n) + integ(-IT("VDD:p") 1120n 1125n) + integ(-IT("VDD:p") 1135n 1140n) + integ(-IT("VDD:p") 1150n 1155n) + integ(-IT("VDD:p") 1165n 1170n) + integ(-IT("VDD:p") 1180n 1185n) + integ(-IT("VDD:p") 1195n 1200n) + integ(-IT("VDD:p") 1210n 1215n) + integ(-IT("VDD:p") 1225n 1230n) + integ(-IT("VDD:p") 1240n 1245n) + integ(-IT("VDD:p") 1255n 1260n) + integ(-IT("VDD:p") 1270n 1275n) + integ(-IT("VDD:p") 1285n 1290n) + integ(-IT("VDD:p") 1300n 1305n) + integ(-IT("VDD:p") 1315n 1320n) + integ(-IT("VDD:p") 1330n 1335n) + integ(-IT("VDD:p") 1345n 1350n) + integ(-IT("VDD:p") 1360n 1365n) + integ(-IT("VDD:p") 1375n 1380n) + integ(-IT("VDD:p") 1390n 1395n) + integ(-IT("VDD:p") 1405n 1410n) + integ(-IT("VDD:p") 1420n 1425n) + integ(-IT("VDD:p") 1435n 1440n) + integ(-IT("VDD:p") 1450n 1455n)) / 32 * 1.2)
close(p)
