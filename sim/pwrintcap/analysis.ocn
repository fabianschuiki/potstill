openResults("./pwrintcap.psf")
selectResult('tran)
p = outfile("pwrintcap.csv", "w")
printf("Characterizing pin CK\n")
fprintf(p, "C_CK,%g\n", integ(abs(IT("X:1")) 1n 3n) / 1.2)
printf("Characterizing pin RE\n")
fprintf(p, "E_RE_rise,%g\n", integ(-IT("VDD:p") 3n 4n) * 1.2)
fprintf(p, "E_RE_fall,%g\n", integ(-IT("VDD:p") 4n 5n) * 1.2)
fprintf(p, "C_RE,%g\n", integ(abs(IT("X:2")) 3n 5n) / 1.2)
printf("Characterizing pin WE\n")
fprintf(p, "E_WE_rise,%g\n", integ(-IT("VDD:p") 5n 6n) * 1.2)
fprintf(p, "E_WE_fall,%g\n", integ(-IT("VDD:p") 6n 7n) * 1.2)
fprintf(p, "C_WE,%g\n", integ(abs(IT("X:13")) 5n 7n) / 1.2)
printf("Characterizing pin RA0\n")
fprintf(p, "E_RA0_rise,%g\n", integ(-IT("VDD:p") 7n 8n) * 1.2)
fprintf(p, "E_RA0_fall,%g\n", integ(-IT("VDD:p") 8n 9n) * 1.2)
fprintf(p, "C_RA0,%g\n", integ(abs(IT("X:3")) 7n 9n) / 1.2)
printf("Characterizing pin RA1\n")
fprintf(p, "E_RA1_rise,%g\n", integ(-IT("VDD:p") 9n 10n) * 1.2)
fprintf(p, "E_RA1_fall,%g\n", integ(-IT("VDD:p") 10n 11n) * 1.2)
fprintf(p, "C_RA1,%g\n", integ(abs(IT("X:4")) 9n 11n) / 1.2)
printf("Characterizing pin WA0\n")
fprintf(p, "E_WA0_rise,%g\n", integ(-IT("VDD:p") 11n 12n) * 1.2)
fprintf(p, "E_WA0_fall,%g\n", integ(-IT("VDD:p") 12n 13n) * 1.2)
fprintf(p, "C_WA0,%g\n", integ(abs(IT("X:14")) 11n 13n) / 1.2)
printf("Characterizing pin WA1\n")
fprintf(p, "E_WA1_rise,%g\n", integ(-IT("VDD:p") 13n 14n) * 1.2)
fprintf(p, "E_WA1_fall,%g\n", integ(-IT("VDD:p") 14n 15n) * 1.2)
fprintf(p, "C_WA1,%g\n", integ(abs(IT("X:15")) 13n 15n) / 1.2)
printf("Characterizing pin WD0\n")
fprintf(p, "E_WD0_rise,%g\n", integ(-IT("VDD:p") 15n 16n) * 1.2)
fprintf(p, "E_WD0_fall,%g\n", integ(-IT("VDD:p") 16n 17n) * 1.2)
fprintf(p, "C_WD0,%g\n", integ(abs(IT("X:16")) 15n 17n) / 1.2)
printf("Characterizing pin WD1\n")
fprintf(p, "E_WD1_rise,%g\n", integ(-IT("VDD:p") 17n 18n) * 1.2)
fprintf(p, "E_WD1_fall,%g\n", integ(-IT("VDD:p") 18n 19n) * 1.2)
fprintf(p, "C_WD1,%g\n", integ(abs(IT("X:17")) 17n 19n) / 1.2)
printf("Characterizing pin WD2\n")
fprintf(p, "E_WD2_rise,%g\n", integ(-IT("VDD:p") 19n 20n) * 1.2)
fprintf(p, "E_WD2_fall,%g\n", integ(-IT("VDD:p") 20n 21n) * 1.2)
fprintf(p, "C_WD2,%g\n", integ(abs(IT("X:18")) 19n 21n) / 1.2)
printf("Characterizing pin WD3\n")
fprintf(p, "E_WD3_rise,%g\n", integ(-IT("VDD:p") 21n 22n) * 1.2)
fprintf(p, "E_WD3_fall,%g\n", integ(-IT("VDD:p") 22n 23n) * 1.2)
fprintf(p, "C_WD3,%g\n", integ(abs(IT("X:19")) 21n 23n) / 1.2)
printf("Characterizing pin WD4\n")
fprintf(p, "E_WD4_rise,%g\n", integ(-IT("VDD:p") 23n 24n) * 1.2)
fprintf(p, "E_WD4_fall,%g\n", integ(-IT("VDD:p") 24n 25n) * 1.2)
fprintf(p, "C_WD4,%g\n", integ(abs(IT("X:20")) 23n 25n) / 1.2)
printf("Characterizing pin WD5\n")
fprintf(p, "E_WD5_rise,%g\n", integ(-IT("VDD:p") 25n 26n) * 1.2)
fprintf(p, "E_WD5_fall,%g\n", integ(-IT("VDD:p") 26n 27n) * 1.2)
fprintf(p, "C_WD5,%g\n", integ(abs(IT("X:21")) 25n 27n) / 1.2)
printf("Characterizing pin WD6\n")
fprintf(p, "E_WD6_rise,%g\n", integ(-IT("VDD:p") 27n 28n) * 1.2)
fprintf(p, "E_WD6_fall,%g\n", integ(-IT("VDD:p") 28n 29n) * 1.2)
fprintf(p, "C_WD6,%g\n", integ(abs(IT("X:22")) 27n 29n) / 1.2)
printf("Characterizing pin WD7\n")
fprintf(p, "E_WD7_rise,%g\n", integ(-IT("VDD:p") 29n 30n) * 1.2)
fprintf(p, "E_WD7_fall,%g\n", integ(-IT("VDD:p") 30n 31n) * 1.2)
fprintf(p, "C_WD7,%g\n", integ(abs(IT("X:23")) 29n 31n) / 1.2)
close(p)
exit
